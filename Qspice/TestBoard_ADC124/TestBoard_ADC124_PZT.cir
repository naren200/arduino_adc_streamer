* TestBoard_ADC124 - 7x PZT (SM311 class) -> TMUX1308A -> OPA365 buffer -> AIN_B4
* GENERATED by build_model.py from config.json - edit the config, not this file.
* Sensor k is connected to MUX pin S<k>; address 7 = VMID reference channel.

* ---- global parameters ----
.param mux_ron=1.200000000e+02
.param mux_ron_vdep=0.000000000e+00
.param mux_vref=1.650000000e+00
.param mux_roff=1.000000000e+12
.param mux_cs_off=2.000000000e-12
.param mux_c_on_extra=2.000000000e-12
.param mux_c_ft=1.000000000e-13
.param mux_qinj=-8.000000000e-13
.param mux_qinj_src_frac=0.000000000e+00
.param mux_ileak_s_off=1.000000000e-09
.param op_gbw=5.000000000e+07
.param op_aol=1.000000000e+06
.param op_sr=2.500000000e+07
.param op_vos=1.000000000e-04
.param op_ib=2.000000000e-13
.param op_cdiff=6.000000000e-12
.param op_ccm=2.000000000e-12
.param op_ro=3.000000000e+01
.param op_vmargin=1.000000000e-02

* ---- behavioral cells ----
* --- begin models/TMUX1308A_channel.lib ---
* TMUX1308A behavioral single-channel cell (one of 8 S pins -> common D pin)
*
* Pins : s  = source pin (S0..S7)
*        d  = common drain pin (D)
*        c  = analog enable, 0 V = off, 1 V = on (generated by the netlist from
*             the address/timing schedule, so ton/toff/edge are configurable)
*
* Global .param values used (all set by build_model.py from config.json):
*   mux_ron, mux_ron_vdep, mux_vref, mux_roff, mux_cs_off, mux_c_on_extra, mux_c_ft,
*   mux_qinj, mux_qinj_src_frac, mux_ileak_s_off
*
* Effects modelled:
*   - on resistance (with a quadratic signal dependence), off isolation
*   - off-state source capacitance, extra capacitance while selected (the datasheet
*     on-capacitance is a single lumped value, so the extra is CON - CSOFF - CDOFF),
*     source-to-drain feedthrough capacitance (from off isolation / crosstalk specs)
*   - charge injection: net charge mux_qinj is delivered when the channel turns
*     off (and removed when it turns on), split between D and S
*   - off-state source->drain leakage (mux_ileak_s_off)
*   Drain-side capacitance and on-state drain leakage are shared by all
*   channels and live in the top-level netlist.
.subckt TMUX_CH s d c
Bsw s d I=V(s,d)*(limit(V(c),0,1)/({mux_ron}*(1+{mux_ron_vdep}*(V(s)-{mux_vref})*(V(s)-{mux_vref}))) + (1-limit(V(c),0,1))/{mux_roff})
Cso s 0 {mux_cs_off}
Cft s d {mux_c_ft}
Con s x {mux_c_on_extra}
Rx  x 0 1G
Bgx x 0 I=V(x)*limit(V(c),0,1)/{mux_ron}
Bqd 0 d I=-{mux_qinj}*(1-{mux_qinj_src_frac})*ddt(limit(V(c),0,1))
Bqs 0 s I=-{mux_qinj}*{mux_qinj_src_frac}*ddt(limit(V(c),0,1))
Bls s d I={mux_ileak_s_off}*(1-limit(V(c),0,1))
.ends TMUX_CH
* --- end models/TMUX1308A_channel.lib ---
* --- begin models/OPA365_behavioral.lib ---
* OPA365 behavioral macro-model (NOT the TI SPICE model)
*
* Pins : inp, inn, out, vdd, gnd
* Single dominant pole (gain-bandwidth), slew limit, rail-to-rail clamp with
* headroom, open-loop output resistance, input offset / bias current /
* input capacitances.
*
* Global .param values used (set by build_model.py from config.json):
*   op_gbw, op_aol, op_sr, op_vos, op_ib, op_cdiff, op_ccm, op_ro, op_vmargin
.param op_gm=1m
.param op_c1={op_gm/(6.283185307*op_gbw)}
.subckt OPA365_BEH inp inn out vdd gnd
Ccmp inp gnd {op_ccm}
Ccmn inn gnd {op_ccm}
Cdif inp inn {op_cdiff}
Ibp  inp gnd {op_ib}
Ibn  inn gnd {op_ib}
Bgm  gnd int I=limit({op_gm}*(V(inp)-V(inn)+{op_vos}), -{op_sr}*{op_c1}, {op_sr}*{op_c1})
Rint int gnd {op_aol/op_gm}
Cint int gnd {op_c1}
Bout outi gnd V=limit(V(int), V(gnd)+{op_vmargin}, V(vdd)-{op_vmargin})
Ro   outi out {op_ro}
.ends OPA365_BEH
* --- end models/OPA365_behavioral.lib ---

* ---- supply and reference ----
Vdd vdd 0 3.3
Vvmid vmid 0 1.65

* ---- PZT sensors: force [N] as volts -> charge source (d33*dF/dt) || Cp || loss ----
* sensor 0 -> S0 (O6_P1B): Cp=60.7 pF, d33=600.0 pC/N
Vf0 f0 0 PWL(0.000000000e+00 0.000000000e+00 5.720000000e-04 0.000000000e+00)
Bq0 0 p0 I=6.000000000e-10*ddt(V(f0))
Cp0 p0 0 6.073972840e-11
Ri0 p0 0 1.000000000e+10
Rt0 p0 s0 1.0
Cpar0 s0 0 3.000000000e-12
Ccpl0 s0 s1 2.000000000e-13
* sensor 1 -> S1 (O6_P2B): Cp=60.7 pF, d33=600.0 pC/N
Vf1 f1 0 PWL(0.000000000e+00 0.000000000e+00 5.720000000e-04 0.000000000e+00)
Bq1 0 p1 I=6.000000000e-10*ddt(V(f1))
Cp1 p1 0 6.073972840e-11
Ri1 p1 0 1.000000000e+10
Rt1 p1 s1 1.0
Cpar1 s1 0 3.000000000e-12
Ccpl1 s1 s2 2.000000000e-13
* sensor 2 -> S2 (O6_P3B): Cp=60.7 pF, d33=600.0 pC/N
Vf2 f2 0 PWL(0.000000000e+00 0.000000000e+00 3.000000000e-05 0.000000000e+00 7.000000000e-05 1.000000000e-01 3.200000000e-04 1.000000000e-01
+ 3.600000000e-04 0.000000000e+00 5.720000000e-04 0.000000000e+00)
Bq2 0 p2 I=6.000000000e-10*ddt(V(f2))
Cp2 p2 0 6.073972840e-11
Ri2 p2 0 1.000000000e+10
Rt2 p2 s2 1.0
Cpar2 s2 0 3.000000000e-12
Ccpl2 s2 s3 2.000000000e-13
* sensor 3 -> S3 (O6_P4B): Cp=60.7 pF, d33=600.0 pC/N
Vf3 f3 0 PWL(0.000000000e+00 0.000000000e+00 5.720000000e-04 0.000000000e+00)
Bq3 0 p3 I=6.000000000e-10*ddt(V(f3))
Cp3 p3 0 6.073972840e-11
Ri3 p3 0 1.000000000e+10
Rt3 p3 s3 1.0
Cpar3 s3 0 3.000000000e-12
Ccpl3 s3 s4 2.000000000e-13
* sensor 4 -> S4 (O6_P5B): Cp=60.7 pF, d33=600.0 pC/N
Vf4 f4 0 PWL(0.000000000e+00 0.000000000e+00 1.500000000e-04 0.000000000e+00 1.900000000e-04 1.500000000e-01 4.500000000e-04 1.500000000e-01
+ 4.900000000e-04 0.000000000e+00 5.720000000e-04 0.000000000e+00)
Bq4 0 p4 I=6.000000000e-10*ddt(V(f4))
Cp4 p4 0 6.073972840e-11
Ri4 p4 0 1.000000000e+10
Rt4 p4 s4 1.0
Cpar4 s4 0 3.000000000e-12
Ccpl4 s4 s5 2.000000000e-13
* sensor 5 -> S5 (O7_P4B): Cp=60.7 pF, d33=600.0 pC/N
Vf5 f5 0 PWL(0.000000000e+00 0.000000000e+00 5.720000000e-04 0.000000000e+00)
Bq5 0 p5 I=6.000000000e-10*ddt(V(f5))
Cp5 p5 0 6.073972840e-11
Ri5 p5 0 1.000000000e+10
Rt5 p5 s5 1.0
Cpar5 s5 0 3.000000000e-12
Ccpl5 s5 s6 2.000000000e-13
* sensor 6 -> S6 (O7_P5B): Cp=60.7 pF, d33=600.0 pC/N
Vf6 f6 0 PWL(0.000000000e+00 0.000000000e+00 5.720000000e-04 0.000000000e+00)
Bq6 0 p6 I=6.000000000e-10*ddt(V(f6))
Cp6 p6 0 6.073972840e-11
Ri6 p6 0 1.000000000e+10
Rt6 p6 s6 1.0
Cpar6 s6 0 3.000000000e-12

* ---- VMID channel (S7): 100 ohm from VMID, 150 pF to ground at the S7 pin ----
R5 vmid s7 100.0
C5 s7 0 1.500000000e-10

* ---- MUX control (analog enables) ----
Vc0 c0 0 PWL(0.000000000e+00 0.000000000e+00 2.002500000e-05 0.000000000e+00 2.002700000e-05 1.000000000e+00 2.700100000e-05 1.000000000e+00
+ 2.700300000e-05 0.000000000e+00 1.530250000e-04 0.000000000e+00 1.530270000e-04 1.000000000e+00 1.600010000e-04 1.000000000e+00
+ 1.600030000e-04 0.000000000e+00 2.860250000e-04 0.000000000e+00 2.860270000e-04 1.000000000e+00 2.930010000e-04 1.000000000e+00
+ 2.930030000e-04 0.000000000e+00 4.190250000e-04 0.000000000e+00 4.190270000e-04 1.000000000e+00 4.260010000e-04 1.000000000e+00
+ 4.260030000e-04 0.000000000e+00)
Vc1 c1 0 PWL(0.000000000e+00 0.000000000e+00 3.902500000e-05 0.000000000e+00 3.902700000e-05 1.000000000e+00 4.600100000e-05 1.000000000e+00
+ 4.600300000e-05 0.000000000e+00 1.720250000e-04 0.000000000e+00 1.720270000e-04 1.000000000e+00 1.790010000e-04 1.000000000e+00
+ 1.790030000e-04 0.000000000e+00 3.050250000e-04 0.000000000e+00 3.050270000e-04 1.000000000e+00 3.120010000e-04 1.000000000e+00
+ 3.120030000e-04 0.000000000e+00 4.380250000e-04 0.000000000e+00 4.380270000e-04 1.000000000e+00 4.450010000e-04 1.000000000e+00
+ 4.450030000e-04 0.000000000e+00)
Vc2 c2 0 PWL(0.000000000e+00 0.000000000e+00 5.802500000e-05 0.000000000e+00 5.802700000e-05 1.000000000e+00 6.500100000e-05 1.000000000e+00
+ 6.500300000e-05 0.000000000e+00 1.910250000e-04 0.000000000e+00 1.910270000e-04 1.000000000e+00 1.980010000e-04 1.000000000e+00
+ 1.980030000e-04 0.000000000e+00 3.240250000e-04 0.000000000e+00 3.240270000e-04 1.000000000e+00 3.310010000e-04 1.000000000e+00
+ 3.310030000e-04 0.000000000e+00 4.570250000e-04 0.000000000e+00 4.570270000e-04 1.000000000e+00 4.640010000e-04 1.000000000e+00
+ 4.640030000e-04 0.000000000e+00)
Vc3 c3 0 PWL(0.000000000e+00 0.000000000e+00 7.702500000e-05 0.000000000e+00 7.702700000e-05 1.000000000e+00 8.400100000e-05 1.000000000e+00
+ 8.400300000e-05 0.000000000e+00 2.100250000e-04 0.000000000e+00 2.100270000e-04 1.000000000e+00 2.170010000e-04 1.000000000e+00
+ 2.170030000e-04 0.000000000e+00 3.430250000e-04 0.000000000e+00 3.430270000e-04 1.000000000e+00 3.500010000e-04 1.000000000e+00
+ 3.500030000e-04 0.000000000e+00 4.760250000e-04 0.000000000e+00 4.760270000e-04 1.000000000e+00 4.830010000e-04 1.000000000e+00
+ 4.830030000e-04 0.000000000e+00)
Vc4 c4 0 PWL(0.000000000e+00 0.000000000e+00 9.602500000e-05 0.000000000e+00 9.602700000e-05 1.000000000e+00 1.030010000e-04 1.000000000e+00
+ 1.030030000e-04 0.000000000e+00 2.290250000e-04 0.000000000e+00 2.290270000e-04 1.000000000e+00 2.360010000e-04 1.000000000e+00
+ 2.360030000e-04 0.000000000e+00 3.620250000e-04 0.000000000e+00 3.620270000e-04 1.000000000e+00 3.690010000e-04 1.000000000e+00
+ 3.690030000e-04 0.000000000e+00 4.950250000e-04 0.000000000e+00 4.950270000e-04 1.000000000e+00 5.020010000e-04 1.000000000e+00
+ 5.020030000e-04 0.000000000e+00)
Vc5 c5 0 PWL(0.000000000e+00 0.000000000e+00 1.150250000e-04 0.000000000e+00 1.150270000e-04 1.000000000e+00 1.220010000e-04 1.000000000e+00
+ 1.220030000e-04 0.000000000e+00 2.480250000e-04 0.000000000e+00 2.480270000e-04 1.000000000e+00 2.550010000e-04 1.000000000e+00
+ 2.550030000e-04 0.000000000e+00 3.810250000e-04 0.000000000e+00 3.810270000e-04 1.000000000e+00 3.880010000e-04 1.000000000e+00
+ 3.880030000e-04 0.000000000e+00 5.140250000e-04 0.000000000e+00 5.140270000e-04 1.000000000e+00 5.210010000e-04 1.000000000e+00
+ 5.210030000e-04 0.000000000e+00)
Vc6 c6 0 PWL(0.000000000e+00 0.000000000e+00 1.340250000e-04 0.000000000e+00 1.340270000e-04 1.000000000e+00 1.410010000e-04 1.000000000e+00
+ 1.410030000e-04 0.000000000e+00 2.670250000e-04 0.000000000e+00 2.670270000e-04 1.000000000e+00 2.740010000e-04 1.000000000e+00
+ 2.740030000e-04 0.000000000e+00 4.000250000e-04 0.000000000e+00 4.000270000e-04 1.000000000e+00 4.070010000e-04 1.000000000e+00
+ 4.070030000e-04 0.000000000e+00 5.330250000e-04 0.000000000e+00 5.330270000e-04 1.000000000e+00 5.400010000e-04 1.000000000e+00
+ 5.400030000e-04 0.000000000e+00)
Vc7 c7 0 PWL(0.000000000e+00 1.000000000e+00 2.702500000e-05 0.000000000e+00 2.702700000e-05 1.000000000e+00 3.900100000e-05 1.000000000e+00
+ 3.900300000e-05 0.000000000e+00 4.602500000e-05 0.000000000e+00 4.602700000e-05 1.000000000e+00 5.800100000e-05 1.000000000e+00
+ 5.800300000e-05 0.000000000e+00 6.502500000e-05 0.000000000e+00 6.502700000e-05 1.000000000e+00 7.700100000e-05 1.000000000e+00
+ 7.700300000e-05 0.000000000e+00 8.402500000e-05 0.000000000e+00 8.402700000e-05 1.000000000e+00 9.600100000e-05 1.000000000e+00
+ 9.600300000e-05 0.000000000e+00 1.030250000e-04 0.000000000e+00 1.030270000e-04 1.000000000e+00 1.150010000e-04 1.000000000e+00
+ 1.150030000e-04 0.000000000e+00 1.220250000e-04 0.000000000e+00 1.220270000e-04 1.000000000e+00 1.340010000e-04 1.000000000e+00
+ 1.340030000e-04 0.000000000e+00 1.410250000e-04 0.000000000e+00 1.410270000e-04 1.000000000e+00 1.530010000e-04 1.000000000e+00
+ 1.530030000e-04 0.000000000e+00 1.600250000e-04 0.000000000e+00 1.600270000e-04 1.000000000e+00 1.720010000e-04 1.000000000e+00
+ 1.720030000e-04 0.000000000e+00 1.790250000e-04 0.000000000e+00 1.790270000e-04 1.000000000e+00 1.910010000e-04 1.000000000e+00
+ 1.910030000e-04 0.000000000e+00 1.980250000e-04 0.000000000e+00 1.980270000e-04 1.000000000e+00 2.100010000e-04 1.000000000e+00
+ 2.100030000e-04 0.000000000e+00 2.170250000e-04 0.000000000e+00 2.170270000e-04 1.000000000e+00 2.290010000e-04 1.000000000e+00
+ 2.290030000e-04 0.000000000e+00 2.360250000e-04 0.000000000e+00 2.360270000e-04 1.000000000e+00 2.480010000e-04 1.000000000e+00
+ 2.480030000e-04 0.000000000e+00 2.550250000e-04 0.000000000e+00 2.550270000e-04 1.000000000e+00 2.670010000e-04 1.000000000e+00
+ 2.670030000e-04 0.000000000e+00 2.740250000e-04 0.000000000e+00 2.740270000e-04 1.000000000e+00 2.860010000e-04 1.000000000e+00
+ 2.860030000e-04 0.000000000e+00 2.930250000e-04 0.000000000e+00 2.930270000e-04 1.000000000e+00 3.050010000e-04 1.000000000e+00
+ 3.050030000e-04 0.000000000e+00 3.120250000e-04 0.000000000e+00 3.120270000e-04 1.000000000e+00 3.240010000e-04 1.000000000e+00
+ 3.240030000e-04 0.000000000e+00 3.310250000e-04 0.000000000e+00 3.310270000e-04 1.000000000e+00 3.430010000e-04 1.000000000e+00
+ 3.430030000e-04 0.000000000e+00 3.500250000e-04 0.000000000e+00 3.500270000e-04 1.000000000e+00 3.620010000e-04 1.000000000e+00
+ 3.620030000e-04 0.000000000e+00 3.690250000e-04 0.000000000e+00 3.690270000e-04 1.000000000e+00 3.810010000e-04 1.000000000e+00
+ 3.810030000e-04 0.000000000e+00 3.880250000e-04 0.000000000e+00 3.880270000e-04 1.000000000e+00 4.000010000e-04 1.000000000e+00
+ 4.000030000e-04 0.000000000e+00 4.070250000e-04 0.000000000e+00 4.070270000e-04 1.000000000e+00 4.190010000e-04 1.000000000e+00
+ 4.190030000e-04 0.000000000e+00 4.260250000e-04 0.000000000e+00 4.260270000e-04 1.000000000e+00 4.380010000e-04 1.000000000e+00
+ 4.380030000e-04 0.000000000e+00 4.450250000e-04 0.000000000e+00 4.450270000e-04 1.000000000e+00 4.570010000e-04 1.000000000e+00
+ 4.570030000e-04 0.000000000e+00 4.640250000e-04 0.000000000e+00 4.640270000e-04 1.000000000e+00 4.760010000e-04 1.000000000e+00
+ 4.760030000e-04 0.000000000e+00 4.830250000e-04 0.000000000e+00 4.830270000e-04 1.000000000e+00 4.950010000e-04 1.000000000e+00
+ 4.950030000e-04 0.000000000e+00 5.020250000e-04 0.000000000e+00 5.020270000e-04 1.000000000e+00 5.140010000e-04 1.000000000e+00
+ 5.140030000e-04 0.000000000e+00 5.210250000e-04 0.000000000e+00 5.210270000e-04 1.000000000e+00 5.330010000e-04 1.000000000e+00
+ 5.330030000e-04 0.000000000e+00 5.400250000e-04 0.000000000e+00 5.400270000e-04 1.000000000e+00)

* ---- TMUX1308A: 8 channels + shared drain parasitics ----
Xch0 s0 muxd c0 TMUX_CH
Xch1 s1 muxd c1 TMUX_CH
Xch2 s2 muxd c2 TMUX_CH
Xch3 s3 muxd c3 TMUX_CH
Xch4 s4 muxd c4 TMUX_CH
Xch5 s5 muxd c5 TMUX_CH
Xch6 s6 muxd c6 TMUX_CH
Xch7 s7 muxd c7 TMUX_CH
Cd muxd 0 7.000000000e-12
Cdtr muxd 0 2.000000000e-12
Ild muxd 0 DC 1.000000000e-09

* ---- OPA365 unity buffer, bias R13 to VMID, output R21/C29 ----
R13 muxd vmid 470000.0
Crb muxd vmid 1.000000000e-13
XU13 muxd bufo bufo vdd 0 OPA365_BEH
R21 bufo ain 33.0
C29 ain 0 4.700000000e-10
Cain ain 0 1.000000000e-12

* ---- initial conditions ----
.ic V(s0)=1.65 V(p0)=1.65 V(s1)=1.65 V(p1)=1.65 V(s2)=1.65 V(p2)=1.65 V(s3)=1.65 V(p3)=1.65 V(s4)=1.65 V(p4)=1.65 V(s5)=1.65 V(p5)=1.65 V(s6)=1.65 V(p6)=1.65

.tran 0 5.720000000e-04 0 5.000000000e-09
.save V(ain) V(bufo) V(muxd) V(vmid) V(s0) V(s1) V(s2) V(s3) V(s4) V(s5) V(s6) V(s7) V(f0) V(f1) V(f2) V(f3) V(f4) V(f5) V(f6) V(c0) V(c1) V(c2) V(c3) V(c4) V(c5) V(c6) V(c7)
.end
