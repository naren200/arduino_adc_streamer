* TestBoard_7953 - 15 PZT sensors -> ADS7953 mux (MXO) -> OPA365 buffer -> AINP -> S/H (one ADC; the other ADC pair parks this mux on VMID)
* GENERATED by build_model.py from config.json - edit the config, not this file.
* Sensor k is on ADS7953 channel Chk; channel 15 is the VMID channel.

* ---- global parameters ----
.param ads_ron=2.000000000e+02
.param ads_roff=1.000000000e+12
.param ads_cs_off=1.000000000e-12
.param ads_c_ft=1.000000000e-13
.param ads_qinj=0.000000000e+00
.param ads_qinj_src_frac=0.000000000e+00
.param ads_ileak=5.957031250e-11
.param op_gbw=5.000000000e+07
.param op_aol=1.000000000e+06
.param op_sr=2.500000000e+07
.param op_vos=1.000000000e-04
.param op_ib=2.000000000e-13
.param op_cdiff=6.000000000e-12
.param op_ccm=2.000000000e-12
.param op_ro=3.000000000e+01
.param op_vmargin=1.000000000e-02

* ---- behavioral cells ----
* --- begin models/ADS7953_mux_channel.lib ---
* ADS7953 internal multiplexer: one channel (Ch0..Ch15 pin -> MXO), behavioral
*
* Pins : s   = channel input pin (Chx)
*        d   = multiplexer output (MXO)
*        c   = analog enable, 0 V = off, 1 V = on (generated by the netlist from the SPI frame schedule)
*
* Global .param values (set by build_model.py from config.json):
*   ads_ron, ads_roff, ads_cs_off, ads_c_ft, ads_qinj, ads_qinj_src_frac, ads_ileak
*
* Datasheet SLAS605C gives the 15 pF input capacitance (modelled at the S/H, not here) and the input leakage at 125 C
* (scaled to the chosen temperature by build_model.py). Ron, pin / feedthrough capacitance and charge injection are NOT
* specified by the datasheet: they are placeholders (charge injection defaults to 0).
.subckt ADS_CH s d c
Bsw s d I=V(s,d)*(limit(V(c),0,1)/{ads_ron} + (1-limit(V(c),0,1))/{ads_roff})
Cso s 0 {ads_cs_off}
Cft s d {ads_c_ft}
Bqd 0 d I=-{ads_qinj}*(1-{ads_qinj_src_frac})*ddt(limit(V(c),0,1))
Bqs 0 s I=-{ads_qinj}*{ads_qinj_src_frac}*ddt(limit(V(c),0,1))
Bls s d I={ads_ileak}*(1-limit(V(c),0,1))
.ends ADS_CH
* --- end models/ADS7953_mux_channel.lib ---
* --- begin models/OPA365_behavioral.lib ---
* OPA365 behavioral macro-model (NOT the TI SPICE model)
*
* Pins : inp, inn, out, vdd, gnd
* Single dominant pole (gain-bandwidth), slew limit, rail-to-rail clamp with
* headroom, open-loop output resistance, input offset / bias current /
* input capacitances.
*
* Global .param values used (set by build_model.py from config.json):
*   op_gbw, op_aol, op_sr, op_vos, op_ib, op_cdiff, op_ccm, op_ro, op_vmargin
.param op_gm=1m
.param op_c1={op_gm/(6.283185307*op_gbw)}
.subckt OPA365_BEH inp inn out vdd gnd
Ccmp inp gnd {op_ccm}
Ccmn inn gnd {op_ccm}
Cdif inp inn {op_cdiff}
Ibp  inp gnd {op_ib}
Ibn  inn gnd {op_ib}
Bgm  gnd int I=limit({op_gm}*(V(inp)-V(inn)+{op_vos}), -{op_sr}*{op_c1}, {op_sr}*{op_c1})
Rint int gnd {op_aol/op_gm}
Cint int gnd {op_c1}
Bout outi gnd V=limit(V(int), V(gnd)+{op_vmargin}, V(vdd)-{op_vmargin})
Ro   outi out {op_ro}
.ends OPA365_BEH
* --- end models/OPA365_behavioral.lib ---

Vdd vdd 0 3.3
Vvmid vmid 0 1.25

* ---- PZT sensors: force [N] as volts -> charge source d33*dF/dt || Cp || insulation ----
* sensor 0 -> Ch0: Cp=60.7 pF, d33=600.0 pC/N
Vf0 f0 0 PWL(0.000000000e+00 0.000000000e+00 3.680000000e-04 0.000000000e+00)
Bq0 0 p0 I=6.000000000e-10*ddt(V(f0))
Cp0 p0 0 6.073972840e-11
Ri0 p0 0 1.000000000e+10
Rt0 p0 s0 1.0
Cpar0 s0 0 3.000000000e-12
Ccpl0 s0 s1 2.000000000e-13
* sensor 1 -> Ch1: Cp=60.7 pF, d33=600.0 pC/N
Vf1 f1 0 PWL(0.000000000e+00 0.000000000e+00 3.680000000e-04 0.000000000e+00)
Bq1 0 p1 I=6.000000000e-10*ddt(V(f1))
Cp1 p1 0 6.073972840e-11
Ri1 p1 0 1.000000000e+10
Rt1 p1 s1 1.0
Cpar1 s1 0 3.000000000e-12
Ccpl1 s1 s2 2.000000000e-13
* sensor 2 -> Ch2: Cp=60.7 pF, d33=600.0 pC/N
Vf2 f2 0 PWL(0.000000000e+00 0.000000000e+00 2.000000000e-05 0.000000000e+00 6.000000000e-05 6.000000000e-02 2.100000000e-04 6.000000000e-02
+ 2.500000000e-04 0.000000000e+00 3.680000000e-04 0.000000000e+00)
Bq2 0 p2 I=6.000000000e-10*ddt(V(f2))
Cp2 p2 0 6.073972840e-11
Ri2 p2 0 1.000000000e+10
Rt2 p2 s2 1.0
Cpar2 s2 0 3.000000000e-12
Ccpl2 s2 s3 2.000000000e-13
* sensor 3 -> Ch3: Cp=60.7 pF, d33=600.0 pC/N
Vf3 f3 0 PWL(0.000000000e+00 0.000000000e+00 3.680000000e-04 0.000000000e+00)
Bq3 0 p3 I=6.000000000e-10*ddt(V(f3))
Cp3 p3 0 6.073972840e-11
Ri3 p3 0 1.000000000e+10
Rt3 p3 s3 1.0
Cpar3 s3 0 3.000000000e-12
Ccpl3 s3 s4 2.000000000e-13
* sensor 4 -> Ch4: Cp=60.7 pF, d33=600.0 pC/N
Vf4 f4 0 PWL(0.000000000e+00 0.000000000e+00 9.000000000e-05 0.000000000e+00 1.300000000e-04 1.000000000e-01 2.800000000e-04 1.000000000e-01
+ 3.200000000e-04 0.000000000e+00 3.680000000e-04 0.000000000e+00)
Bq4 0 p4 I=6.000000000e-10*ddt(V(f4))
Cp4 p4 0 6.073972840e-11
Ri4 p4 0 1.000000000e+10
Rt4 p4 s4 1.0
Cpar4 s4 0 3.000000000e-12
Ccpl4 s4 s5 2.000000000e-13
* sensor 5 -> Ch5: Cp=60.7 pF, d33=600.0 pC/N
Vf5 f5 0 PWL(0.000000000e+00 0.000000000e+00 3.680000000e-04 0.000000000e+00)
Bq5 0 p5 I=6.000000000e-10*ddt(V(f5))
Cp5 p5 0 6.073972840e-11
Ri5 p5 0 1.000000000e+10
Rt5 p5 s5 1.0
Cpar5 s5 0 3.000000000e-12
Ccpl5 s5 s6 2.000000000e-13
* sensor 6 -> Ch6: Cp=60.7 pF, d33=600.0 pC/N
Vf6 f6 0 PWL(0.000000000e+00 0.000000000e+00 3.680000000e-04 0.000000000e+00)
Bq6 0 p6 I=6.000000000e-10*ddt(V(f6))
Cp6 p6 0 6.073972840e-11
Ri6 p6 0 1.000000000e+10
Rt6 p6 s6 1.0
Cpar6 s6 0 3.000000000e-12
Ccpl6 s6 s7 2.000000000e-13
* sensor 7 -> Ch7: Cp=60.7 pF, d33=600.0 pC/N
Vf7 f7 0 PWL(0.000000000e+00 0.000000000e+00 3.680000000e-04 0.000000000e+00)
Bq7 0 p7 I=6.000000000e-10*ddt(V(f7))
Cp7 p7 0 6.073972840e-11
Ri7 p7 0 1.000000000e+10
Rt7 p7 s7 1.0
Cpar7 s7 0 3.000000000e-12
Ccpl7 s7 s8 2.000000000e-13
* sensor 8 -> Ch8: Cp=60.7 pF, d33=600.0 pC/N
Vf8 f8 0 PWL(0.000000000e+00 0.000000000e+00 3.680000000e-04 0.000000000e+00)
Bq8 0 p8 I=6.000000000e-10*ddt(V(f8))
Cp8 p8 0 6.073972840e-11
Ri8 p8 0 1.000000000e+10
Rt8 p8 s8 1.0
Cpar8 s8 0 3.000000000e-12
Ccpl8 s8 s9 2.000000000e-13
* sensor 9 -> Ch9: Cp=60.7 pF, d33=600.0 pC/N
Vf9 f9 0 PWL(0.000000000e+00 0.000000000e+00 3.680000000e-04 0.000000000e+00)
Bq9 0 p9 I=6.000000000e-10*ddt(V(f9))
Cp9 p9 0 6.073972840e-11
Ri9 p9 0 1.000000000e+10
Rt9 p9 s9 1.0
Cpar9 s9 0 3.000000000e-12
Ccpl9 s9 s10 2.000000000e-13
* sensor 10 -> Ch10: Cp=60.7 pF, d33=600.0 pC/N
Vf10 f10 0 PWL(0.000000000e+00 0.000000000e+00 3.680000000e-04 0.000000000e+00)
Bq10 0 p10 I=6.000000000e-10*ddt(V(f10))
Cp10 p10 0 6.073972840e-11
Ri10 p10 0 1.000000000e+10
Rt10 p10 s10 1.0
Cpar10 s10 0 3.000000000e-12
Ccpl10 s10 s11 2.000000000e-13
* sensor 11 -> Ch11: Cp=60.7 pF, d33=600.0 pC/N
Vf11 f11 0 PWL(0.000000000e+00 0.000000000e+00 3.680000000e-04 0.000000000e+00)
Bq11 0 p11 I=6.000000000e-10*ddt(V(f11))
Cp11 p11 0 6.073972840e-11
Ri11 p11 0 1.000000000e+10
Rt11 p11 s11 1.0
Cpar11 s11 0 3.000000000e-12
Ccpl11 s11 s12 2.000000000e-13
* sensor 12 -> Ch12: Cp=60.7 pF, d33=600.0 pC/N
Vf12 f12 0 PWL(0.000000000e+00 0.000000000e+00 3.680000000e-04 0.000000000e+00)
Bq12 0 p12 I=6.000000000e-10*ddt(V(f12))
Cp12 p12 0 6.073972840e-11
Ri12 p12 0 1.000000000e+10
Rt12 p12 s12 1.0
Cpar12 s12 0 3.000000000e-12
Ccpl12 s12 s13 2.000000000e-13
* sensor 13 -> Ch13: Cp=60.7 pF, d33=600.0 pC/N
Vf13 f13 0 PWL(0.000000000e+00 0.000000000e+00 3.680000000e-04 0.000000000e+00)
Bq13 0 p13 I=6.000000000e-10*ddt(V(f13))
Cp13 p13 0 6.073972840e-11
Ri13 p13 0 1.000000000e+10
Rt13 p13 s13 1.0
Cpar13 s13 0 3.000000000e-12
Ccpl13 s13 s14 2.000000000e-13
* sensor 14 -> Ch14: Cp=60.7 pF, d33=600.0 pC/N
Vf14 f14 0 PWL(0.000000000e+00 0.000000000e+00 3.680000000e-04 0.000000000e+00)
Bq14 0 p14 I=6.000000000e-10*ddt(V(f14))
Cp14 p14 0 6.073972840e-11
Ri14 p14 0 1.000000000e+10
Rt14 p14 s14 1.0
Cpar14 s14 0 3.000000000e-12

* ---- VMID channel (Ch15) ----
R5 vmid s15 100.0
C5 s15 0 1.500000000e-10

* ---- mux channel enables (from the SPI frame schedule) ----
Vc0 c0 0 PWL(0.000000000e+00 0.000000000e+00 3.611000000e-05 0.000000000e+00 3.611200000e-05 1.000000000e+00 3.810200000e-05 1.000000000e+00
+ 3.810400000e-05 0.000000000e+00 9.411000000e-05 0.000000000e+00 9.411200000e-05 1.000000000e+00 9.610200000e-05 1.000000000e+00
+ 9.610400000e-05 0.000000000e+00 1.521100000e-04 0.000000000e+00 1.521120000e-04 1.000000000e+00 1.541020000e-04 1.000000000e+00
+ 1.541040000e-04 0.000000000e+00 2.101100000e-04 0.000000000e+00 2.101120000e-04 1.000000000e+00 2.121020000e-04 1.000000000e+00
+ 2.121040000e-04 0.000000000e+00 2.681100000e-04 0.000000000e+00 2.681120000e-04 1.000000000e+00 2.701020000e-04 1.000000000e+00
+ 2.701040000e-04 0.000000000e+00 3.261100000e-04 0.000000000e+00 3.261120000e-04 1.000000000e+00 3.281020000e-04 1.000000000e+00
+ 3.281040000e-04 0.000000000e+00)
Vc1 c1 0 PWL(0.000000000e+00 0.000000000e+00 3.811000000e-05 0.000000000e+00 3.811200000e-05 1.000000000e+00 4.010200000e-05 1.000000000e+00
+ 4.010400000e-05 0.000000000e+00 9.611000000e-05 0.000000000e+00 9.611200000e-05 1.000000000e+00 9.810200000e-05 1.000000000e+00
+ 9.810400000e-05 0.000000000e+00 1.541100000e-04 0.000000000e+00 1.541120000e-04 1.000000000e+00 1.561020000e-04 1.000000000e+00
+ 1.561040000e-04 0.000000000e+00 2.121100000e-04 0.000000000e+00 2.121120000e-04 1.000000000e+00 2.141020000e-04 1.000000000e+00
+ 2.141040000e-04 0.000000000e+00 2.701100000e-04 0.000000000e+00 2.701120000e-04 1.000000000e+00 2.721020000e-04 1.000000000e+00
+ 2.721040000e-04 0.000000000e+00 3.281100000e-04 0.000000000e+00 3.281120000e-04 1.000000000e+00 3.301020000e-04 1.000000000e+00
+ 3.301040000e-04 0.000000000e+00)
Vc2 c2 0 PWL(0.000000000e+00 0.000000000e+00 4.011000000e-05 0.000000000e+00 4.011200000e-05 1.000000000e+00 4.210200000e-05 1.000000000e+00
+ 4.210400000e-05 0.000000000e+00 9.811000000e-05 0.000000000e+00 9.811200000e-05 1.000000000e+00 1.001020000e-04 1.000000000e+00
+ 1.001040000e-04 0.000000000e+00 1.561100000e-04 0.000000000e+00 1.561120000e-04 1.000000000e+00 1.581020000e-04 1.000000000e+00
+ 1.581040000e-04 0.000000000e+00 2.141100000e-04 0.000000000e+00 2.141120000e-04 1.000000000e+00 2.161020000e-04 1.000000000e+00
+ 2.161040000e-04 0.000000000e+00 2.721100000e-04 0.000000000e+00 2.721120000e-04 1.000000000e+00 2.741020000e-04 1.000000000e+00
+ 2.741040000e-04 0.000000000e+00 3.301100000e-04 0.000000000e+00 3.301120000e-04 1.000000000e+00 3.321020000e-04 1.000000000e+00
+ 3.321040000e-04 0.000000000e+00)
Vc3 c3 0 PWL(0.000000000e+00 0.000000000e+00 4.211000000e-05 0.000000000e+00 4.211200000e-05 1.000000000e+00 4.410200000e-05 1.000000000e+00
+ 4.410400000e-05 0.000000000e+00 1.001100000e-04 0.000000000e+00 1.001120000e-04 1.000000000e+00 1.021020000e-04 1.000000000e+00
+ 1.021040000e-04 0.000000000e+00 1.581100000e-04 0.000000000e+00 1.581120000e-04 1.000000000e+00 1.601020000e-04 1.000000000e+00
+ 1.601040000e-04 0.000000000e+00 2.161100000e-04 0.000000000e+00 2.161120000e-04 1.000000000e+00 2.181020000e-04 1.000000000e+00
+ 2.181040000e-04 0.000000000e+00 2.741100000e-04 0.000000000e+00 2.741120000e-04 1.000000000e+00 2.761020000e-04 1.000000000e+00
+ 2.761040000e-04 0.000000000e+00 3.321100000e-04 0.000000000e+00 3.321120000e-04 1.000000000e+00 3.341020000e-04 1.000000000e+00
+ 3.341040000e-04 0.000000000e+00)
Vc4 c4 0 PWL(0.000000000e+00 0.000000000e+00 4.411000000e-05 0.000000000e+00 4.411200000e-05 1.000000000e+00 4.610200000e-05 1.000000000e+00
+ 4.610400000e-05 0.000000000e+00 1.021100000e-04 0.000000000e+00 1.021120000e-04 1.000000000e+00 1.041020000e-04 1.000000000e+00
+ 1.041040000e-04 0.000000000e+00 1.601100000e-04 0.000000000e+00 1.601120000e-04 1.000000000e+00 1.621020000e-04 1.000000000e+00
+ 1.621040000e-04 0.000000000e+00 2.181100000e-04 0.000000000e+00 2.181120000e-04 1.000000000e+00 2.201020000e-04 1.000000000e+00
+ 2.201040000e-04 0.000000000e+00 2.761100000e-04 0.000000000e+00 2.761120000e-04 1.000000000e+00 2.781020000e-04 1.000000000e+00
+ 2.781040000e-04 0.000000000e+00 3.341100000e-04 0.000000000e+00 3.341120000e-04 1.000000000e+00 3.361020000e-04 1.000000000e+00
+ 3.361040000e-04 0.000000000e+00)
Vc5 c5 0 PWL(0.000000000e+00 0.000000000e+00 4.611000000e-05 0.000000000e+00 4.611200000e-05 1.000000000e+00 4.810200000e-05 1.000000000e+00
+ 4.810400000e-05 0.000000000e+00 1.041100000e-04 0.000000000e+00 1.041120000e-04 1.000000000e+00 1.061020000e-04 1.000000000e+00
+ 1.061040000e-04 0.000000000e+00 1.621100000e-04 0.000000000e+00 1.621120000e-04 1.000000000e+00 1.641020000e-04 1.000000000e+00
+ 1.641040000e-04 0.000000000e+00 2.201100000e-04 0.000000000e+00 2.201120000e-04 1.000000000e+00 2.221020000e-04 1.000000000e+00
+ 2.221040000e-04 0.000000000e+00 2.781100000e-04 0.000000000e+00 2.781120000e-04 1.000000000e+00 2.801020000e-04 1.000000000e+00
+ 2.801040000e-04 0.000000000e+00 3.361100000e-04 0.000000000e+00 3.361120000e-04 1.000000000e+00 3.381020000e-04 1.000000000e+00
+ 3.381040000e-04 0.000000000e+00)
Vc6 c6 0 PWL(0.000000000e+00 0.000000000e+00 4.811000000e-05 0.000000000e+00 4.811200000e-05 1.000000000e+00 5.010200000e-05 1.000000000e+00
+ 5.010400000e-05 0.000000000e+00 1.061100000e-04 0.000000000e+00 1.061120000e-04 1.000000000e+00 1.081020000e-04 1.000000000e+00
+ 1.081040000e-04 0.000000000e+00 1.641100000e-04 0.000000000e+00 1.641120000e-04 1.000000000e+00 1.661020000e-04 1.000000000e+00
+ 1.661040000e-04 0.000000000e+00 2.221100000e-04 0.000000000e+00 2.221120000e-04 1.000000000e+00 2.241020000e-04 1.000000000e+00
+ 2.241040000e-04 0.000000000e+00 2.801100000e-04 0.000000000e+00 2.801120000e-04 1.000000000e+00 2.821020000e-04 1.000000000e+00
+ 2.821040000e-04 0.000000000e+00 3.381100000e-04 0.000000000e+00 3.381120000e-04 1.000000000e+00 3.401020000e-04 1.000000000e+00
+ 3.401040000e-04 0.000000000e+00)
Vc7 c7 0 PWL(0.000000000e+00 0.000000000e+00 5.011000000e-05 0.000000000e+00 5.011200000e-05 1.000000000e+00 5.210200000e-05 1.000000000e+00
+ 5.210400000e-05 0.000000000e+00 1.081100000e-04 0.000000000e+00 1.081120000e-04 1.000000000e+00 1.101020000e-04 1.000000000e+00
+ 1.101040000e-04 0.000000000e+00 1.661100000e-04 0.000000000e+00 1.661120000e-04 1.000000000e+00 1.681020000e-04 1.000000000e+00
+ 1.681040000e-04 0.000000000e+00 2.241100000e-04 0.000000000e+00 2.241120000e-04 1.000000000e+00 2.261020000e-04 1.000000000e+00
+ 2.261040000e-04 0.000000000e+00 2.821100000e-04 0.000000000e+00 2.821120000e-04 1.000000000e+00 2.841020000e-04 1.000000000e+00
+ 2.841040000e-04 0.000000000e+00 3.401100000e-04 0.000000000e+00 3.401120000e-04 1.000000000e+00 3.421020000e-04 1.000000000e+00
+ 3.421040000e-04 0.000000000e+00)
Vc8 c8 0 PWL(0.000000000e+00 0.000000000e+00 5.211000000e-05 0.000000000e+00 5.211200000e-05 1.000000000e+00 5.410200000e-05 1.000000000e+00
+ 5.410400000e-05 0.000000000e+00 1.101100000e-04 0.000000000e+00 1.101120000e-04 1.000000000e+00 1.121020000e-04 1.000000000e+00
+ 1.121040000e-04 0.000000000e+00 1.681100000e-04 0.000000000e+00 1.681120000e-04 1.000000000e+00 1.701020000e-04 1.000000000e+00
+ 1.701040000e-04 0.000000000e+00 2.261100000e-04 0.000000000e+00 2.261120000e-04 1.000000000e+00 2.281020000e-04 1.000000000e+00
+ 2.281040000e-04 0.000000000e+00 2.841100000e-04 0.000000000e+00 2.841120000e-04 1.000000000e+00 2.861020000e-04 1.000000000e+00
+ 2.861040000e-04 0.000000000e+00 3.421100000e-04 0.000000000e+00 3.421120000e-04 1.000000000e+00 3.441020000e-04 1.000000000e+00
+ 3.441040000e-04 0.000000000e+00)
Vc9 c9 0 PWL(0.000000000e+00 0.000000000e+00 5.411000000e-05 0.000000000e+00 5.411200000e-05 1.000000000e+00 5.610200000e-05 1.000000000e+00
+ 5.610400000e-05 0.000000000e+00 1.121100000e-04 0.000000000e+00 1.121120000e-04 1.000000000e+00 1.141020000e-04 1.000000000e+00
+ 1.141040000e-04 0.000000000e+00 1.701100000e-04 0.000000000e+00 1.701120000e-04 1.000000000e+00 1.721020000e-04 1.000000000e+00
+ 1.721040000e-04 0.000000000e+00 2.281100000e-04 0.000000000e+00 2.281120000e-04 1.000000000e+00 2.301020000e-04 1.000000000e+00
+ 2.301040000e-04 0.000000000e+00 2.861100000e-04 0.000000000e+00 2.861120000e-04 1.000000000e+00 2.881020000e-04 1.000000000e+00
+ 2.881040000e-04 0.000000000e+00 3.441100000e-04 0.000000000e+00 3.441120000e-04 1.000000000e+00 3.461020000e-04 1.000000000e+00
+ 3.461040000e-04 0.000000000e+00)
Vc10 c10 0 PWL(0.000000000e+00 0.000000000e+00 5.611000000e-05 0.000000000e+00 5.611200000e-05 1.000000000e+00 5.810200000e-05 1.000000000e+00
+ 5.810400000e-05 0.000000000e+00 1.141100000e-04 0.000000000e+00 1.141120000e-04 1.000000000e+00 1.161020000e-04 1.000000000e+00
+ 1.161040000e-04 0.000000000e+00 1.721100000e-04 0.000000000e+00 1.721120000e-04 1.000000000e+00 1.741020000e-04 1.000000000e+00
+ 1.741040000e-04 0.000000000e+00 2.301100000e-04 0.000000000e+00 2.301120000e-04 1.000000000e+00 2.321020000e-04 1.000000000e+00
+ 2.321040000e-04 0.000000000e+00 2.881100000e-04 0.000000000e+00 2.881120000e-04 1.000000000e+00 2.901020000e-04 1.000000000e+00
+ 2.901040000e-04 0.000000000e+00 3.461100000e-04 0.000000000e+00 3.461120000e-04 1.000000000e+00 3.481020000e-04 1.000000000e+00
+ 3.481040000e-04 0.000000000e+00)
Vc11 c11 0 PWL(0.000000000e+00 0.000000000e+00 5.811000000e-05 0.000000000e+00 5.811200000e-05 1.000000000e+00 6.010200000e-05 1.000000000e+00
+ 6.010400000e-05 0.000000000e+00 1.161100000e-04 0.000000000e+00 1.161120000e-04 1.000000000e+00 1.181020000e-04 1.000000000e+00
+ 1.181040000e-04 0.000000000e+00 1.741100000e-04 0.000000000e+00 1.741120000e-04 1.000000000e+00 1.761020000e-04 1.000000000e+00
+ 1.761040000e-04 0.000000000e+00 2.321100000e-04 0.000000000e+00 2.321120000e-04 1.000000000e+00 2.341020000e-04 1.000000000e+00
+ 2.341040000e-04 0.000000000e+00 2.901100000e-04 0.000000000e+00 2.901120000e-04 1.000000000e+00 2.921020000e-04 1.000000000e+00
+ 2.921040000e-04 0.000000000e+00 3.481100000e-04 0.000000000e+00 3.481120000e-04 1.000000000e+00 3.501020000e-04 1.000000000e+00
+ 3.501040000e-04 0.000000000e+00)
Vc12 c12 0 PWL(0.000000000e+00 0.000000000e+00 6.011000000e-05 0.000000000e+00 6.011200000e-05 1.000000000e+00 6.210200000e-05 1.000000000e+00
+ 6.210400000e-05 0.000000000e+00 1.181100000e-04 0.000000000e+00 1.181120000e-04 1.000000000e+00 1.201020000e-04 1.000000000e+00
+ 1.201040000e-04 0.000000000e+00 1.761100000e-04 0.000000000e+00 1.761120000e-04 1.000000000e+00 1.781020000e-04 1.000000000e+00
+ 1.781040000e-04 0.000000000e+00 2.341100000e-04 0.000000000e+00 2.341120000e-04 1.000000000e+00 2.361020000e-04 1.000000000e+00
+ 2.361040000e-04 0.000000000e+00 2.921100000e-04 0.000000000e+00 2.921120000e-04 1.000000000e+00 2.941020000e-04 1.000000000e+00
+ 2.941040000e-04 0.000000000e+00 3.501100000e-04 0.000000000e+00 3.501120000e-04 1.000000000e+00 3.521020000e-04 1.000000000e+00
+ 3.521040000e-04 0.000000000e+00)
Vc13 c13 0 PWL(0.000000000e+00 0.000000000e+00 6.211000000e-05 0.000000000e+00 6.211200000e-05 1.000000000e+00 6.410200000e-05 1.000000000e+00
+ 6.410400000e-05 0.000000000e+00 1.201100000e-04 0.000000000e+00 1.201120000e-04 1.000000000e+00 1.221020000e-04 1.000000000e+00
+ 1.221040000e-04 0.000000000e+00 1.781100000e-04 0.000000000e+00 1.781120000e-04 1.000000000e+00 1.801020000e-04 1.000000000e+00
+ 1.801040000e-04 0.000000000e+00 2.361100000e-04 0.000000000e+00 2.361120000e-04 1.000000000e+00 2.381020000e-04 1.000000000e+00
+ 2.381040000e-04 0.000000000e+00 2.941100000e-04 0.000000000e+00 2.941120000e-04 1.000000000e+00 2.961020000e-04 1.000000000e+00
+ 2.961040000e-04 0.000000000e+00 3.521100000e-04 0.000000000e+00 3.521120000e-04 1.000000000e+00 3.541020000e-04 1.000000000e+00
+ 3.541040000e-04 0.000000000e+00)
Vc14 c14 0 PWL(0.000000000e+00 0.000000000e+00 6.411000000e-05 0.000000000e+00 6.411200000e-05 1.000000000e+00 6.610200000e-05 1.000000000e+00
+ 6.610400000e-05 0.000000000e+00 1.221100000e-04 0.000000000e+00 1.221120000e-04 1.000000000e+00 1.241020000e-04 1.000000000e+00
+ 1.241040000e-04 0.000000000e+00 1.801100000e-04 0.000000000e+00 1.801120000e-04 1.000000000e+00 1.821020000e-04 1.000000000e+00
+ 1.821040000e-04 0.000000000e+00 2.381100000e-04 0.000000000e+00 2.381120000e-04 1.000000000e+00 2.401020000e-04 1.000000000e+00
+ 2.401040000e-04 0.000000000e+00 2.961100000e-04 0.000000000e+00 2.961120000e-04 1.000000000e+00 2.981020000e-04 1.000000000e+00
+ 2.981040000e-04 0.000000000e+00 3.541100000e-04 0.000000000e+00 3.541120000e-04 1.000000000e+00 3.561020000e-04 1.000000000e+00
+ 3.561040000e-04 0.000000000e+00)
Vc15 c15 0 PWL(0.000000000e+00 1.000000000e+00 3.610200000e-05 1.000000000e+00 3.610400000e-05 0.000000000e+00 6.611000000e-05 0.000000000e+00
+ 6.611200000e-05 1.000000000e+00 9.410200000e-05 1.000000000e+00 9.410400000e-05 0.000000000e+00 1.241100000e-04 0.000000000e+00
+ 1.241120000e-04 1.000000000e+00 1.521020000e-04 1.000000000e+00 1.521040000e-04 0.000000000e+00 1.821100000e-04 0.000000000e+00
+ 1.821120000e-04 1.000000000e+00 2.101020000e-04 1.000000000e+00 2.101040000e-04 0.000000000e+00 2.401100000e-04 0.000000000e+00
+ 2.401120000e-04 1.000000000e+00 2.681020000e-04 1.000000000e+00 2.681040000e-04 0.000000000e+00 2.981100000e-04 0.000000000e+00
+ 2.981120000e-04 1.000000000e+00 3.261020000e-04 1.000000000e+00 3.261040000e-04 0.000000000e+00 3.561100000e-04 0.000000000e+00
+ 3.561120000e-04 1.000000000e+00)

* ---- ADS7953 mux: 16 channels -> MXO ----
Xch0 s0 mxo c0 ADS_CH
Xch1 s1 mxo c1 ADS_CH
Xch2 s2 mxo c2 ADS_CH
Xch3 s3 mxo c3 ADS_CH
Xch4 s4 mxo c4 ADS_CH
Xch5 s5 mxo c5 ADS_CH
Xch6 s6 mxo c6 ADS_CH
Xch7 s7 mxo c7 ADS_CH
Xch8 s8 mxo c8 ADS_CH
Xch9 s9 mxo c9 ADS_CH
Xch10 s10 mxo c10 ADS_CH
Xch11 s11 mxo c11 ADS_CH
Xch12 s12 mxo c12 ADS_CH
Xch13 s13 mxo c13 ADS_CH
Xch14 s14 mxo c14 ADS_CH
Xch15 s15 mxo c15 ADS_CH
Cmxo mxo 0 1.000000000e-11

* ---- OPA365 unity buffer, bias resistor to VMID, buffer output -> AINP, ADC sample-and-hold ----
Rbias mxo vmid 470000.0
XU mxo bufo bufo vdd 0 OPA365_BEH
Rout bufo ain 100.0
Cain ain 0 1.500000000e-10
Bsh ain sh I=V(ain,sh)*limit(V(shc),0,1)/200.0
Csh sh 0 1.500000000e-11
Vshc shc 0 PWL(0.000000000e+00 1.000000000e+00 3.400000000e-05 1.000000000e+00 3.400100000e-05 0.000000000e+00 3.467500000e-05 0.000000000e+00
+ 3.467600000e-05 1.000000000e+00 3.600000000e-05 1.000000000e+00 3.600100000e-05 0.000000000e+00 3.667500000e-05 0.000000000e+00
+ 3.667600000e-05 1.000000000e+00 3.800000000e-05 1.000000000e+00 3.800100000e-05 0.000000000e+00 3.867500000e-05 0.000000000e+00
+ 3.867600000e-05 1.000000000e+00 4.000000000e-05 1.000000000e+00 4.000100000e-05 0.000000000e+00 4.067500000e-05 0.000000000e+00
+ 4.067600000e-05 1.000000000e+00 4.200000000e-05 1.000000000e+00 4.200100000e-05 0.000000000e+00 4.267500000e-05 0.000000000e+00
+ 4.267600000e-05 1.000000000e+00 4.400000000e-05 1.000000000e+00 4.400100000e-05 0.000000000e+00 4.467500000e-05 0.000000000e+00
+ 4.467600000e-05 1.000000000e+00 4.600000000e-05 1.000000000e+00 4.600100000e-05 0.000000000e+00 4.667500000e-05 0.000000000e+00
+ 4.667600000e-05 1.000000000e+00 4.800000000e-05 1.000000000e+00 4.800100000e-05 0.000000000e+00 4.867500000e-05 0.000000000e+00
+ 4.867600000e-05 1.000000000e+00 5.000000000e-05 1.000000000e+00 5.000100000e-05 0.000000000e+00 5.067500000e-05 0.000000000e+00
+ 5.067600000e-05 1.000000000e+00 5.200000000e-05 1.000000000e+00 5.200100000e-05 0.000000000e+00 5.267500000e-05 0.000000000e+00
+ 5.267600000e-05 1.000000000e+00 5.400000000e-05 1.000000000e+00 5.400100000e-05 0.000000000e+00 5.467500000e-05 0.000000000e+00
+ 5.467600000e-05 1.000000000e+00 5.600000000e-05 1.000000000e+00 5.600100000e-05 0.000000000e+00 5.667500000e-05 0.000000000e+00
+ 5.667600000e-05 1.000000000e+00 5.800000000e-05 1.000000000e+00 5.800100000e-05 0.000000000e+00 5.867500000e-05 0.000000000e+00
+ 5.867600000e-05 1.000000000e+00 6.000000000e-05 1.000000000e+00 6.000100000e-05 0.000000000e+00 6.067500000e-05 0.000000000e+00
+ 6.067600000e-05 1.000000000e+00 6.200000000e-05 1.000000000e+00 6.200100000e-05 0.000000000e+00 6.267500000e-05 0.000000000e+00
+ 6.267600000e-05 1.000000000e+00 6.400000000e-05 1.000000000e+00 6.400100000e-05 0.000000000e+00 6.467500000e-05 0.000000000e+00
+ 6.467600000e-05 1.000000000e+00 6.600000000e-05 1.000000000e+00 6.600100000e-05 0.000000000e+00 6.667500000e-05 0.000000000e+00
+ 6.667600000e-05 1.000000000e+00 9.200000000e-05 1.000000000e+00 9.200100000e-05 0.000000000e+00 9.267500000e-05 0.000000000e+00
+ 9.267600000e-05 1.000000000e+00 9.400000000e-05 1.000000000e+00 9.400100000e-05 0.000000000e+00 9.467500000e-05 0.000000000e+00
+ 9.467600000e-05 1.000000000e+00 9.600000000e-05 1.000000000e+00 9.600100000e-05 0.000000000e+00 9.667500000e-05 0.000000000e+00
+ 9.667600000e-05 1.000000000e+00 9.800000000e-05 1.000000000e+00 9.800100000e-05 0.000000000e+00 9.867500000e-05 0.000000000e+00
+ 9.867600000e-05 1.000000000e+00 1.000000000e-04 1.000000000e+00 1.000010000e-04 0.000000000e+00 1.006750000e-04 0.000000000e+00
+ 1.006760000e-04 1.000000000e+00 1.020000000e-04 1.000000000e+00 1.020010000e-04 0.000000000e+00 1.026750000e-04 0.000000000e+00
+ 1.026760000e-04 1.000000000e+00 1.040000000e-04 1.000000000e+00 1.040010000e-04 0.000000000e+00 1.046750000e-04 0.000000000e+00
+ 1.046760000e-04 1.000000000e+00 1.060000000e-04 1.000000000e+00 1.060010000e-04 0.000000000e+00 1.066750000e-04 0.000000000e+00
+ 1.066760000e-04 1.000000000e+00 1.080000000e-04 1.000000000e+00 1.080010000e-04 0.000000000e+00 1.086750000e-04 0.000000000e+00
+ 1.086760000e-04 1.000000000e+00 1.100000000e-04 1.000000000e+00 1.100010000e-04 0.000000000e+00 1.106750000e-04 0.000000000e+00
+ 1.106760000e-04 1.000000000e+00 1.120000000e-04 1.000000000e+00 1.120010000e-04 0.000000000e+00 1.126750000e-04 0.000000000e+00
+ 1.126760000e-04 1.000000000e+00 1.140000000e-04 1.000000000e+00 1.140010000e-04 0.000000000e+00 1.146750000e-04 0.000000000e+00
+ 1.146760000e-04 1.000000000e+00 1.160000000e-04 1.000000000e+00 1.160010000e-04 0.000000000e+00 1.166750000e-04 0.000000000e+00
+ 1.166760000e-04 1.000000000e+00 1.180000000e-04 1.000000000e+00 1.180010000e-04 0.000000000e+00 1.186750000e-04 0.000000000e+00
+ 1.186760000e-04 1.000000000e+00 1.200000000e-04 1.000000000e+00 1.200010000e-04 0.000000000e+00 1.206750000e-04 0.000000000e+00
+ 1.206760000e-04 1.000000000e+00 1.220000000e-04 1.000000000e+00 1.220010000e-04 0.000000000e+00 1.226750000e-04 0.000000000e+00
+ 1.226760000e-04 1.000000000e+00 1.240000000e-04 1.000000000e+00 1.240010000e-04 0.000000000e+00 1.246750000e-04 0.000000000e+00
+ 1.246760000e-04 1.000000000e+00 1.500000000e-04 1.000000000e+00 1.500010000e-04 0.000000000e+00 1.506750000e-04 0.000000000e+00
+ 1.506760000e-04 1.000000000e+00 1.520000000e-04 1.000000000e+00 1.520010000e-04 0.000000000e+00 1.526750000e-04 0.000000000e+00
+ 1.526760000e-04 1.000000000e+00 1.540000000e-04 1.000000000e+00 1.540010000e-04 0.000000000e+00 1.546750000e-04 0.000000000e+00
+ 1.546760000e-04 1.000000000e+00 1.560000000e-04 1.000000000e+00 1.560010000e-04 0.000000000e+00 1.566750000e-04 0.000000000e+00
+ 1.566760000e-04 1.000000000e+00 1.580000000e-04 1.000000000e+00 1.580010000e-04 0.000000000e+00 1.586750000e-04 0.000000000e+00
+ 1.586760000e-04 1.000000000e+00 1.600000000e-04 1.000000000e+00 1.600010000e-04 0.000000000e+00 1.606750000e-04 0.000000000e+00
+ 1.606760000e-04 1.000000000e+00 1.620000000e-04 1.000000000e+00 1.620010000e-04 0.000000000e+00 1.626750000e-04 0.000000000e+00
+ 1.626760000e-04 1.000000000e+00 1.640000000e-04 1.000000000e+00 1.640010000e-04 0.000000000e+00 1.646750000e-04 0.000000000e+00
+ 1.646760000e-04 1.000000000e+00 1.660000000e-04 1.000000000e+00 1.660010000e-04 0.000000000e+00 1.666750000e-04 0.000000000e+00
+ 1.666760000e-04 1.000000000e+00 1.680000000e-04 1.000000000e+00 1.680010000e-04 0.000000000e+00 1.686750000e-04 0.000000000e+00
+ 1.686760000e-04 1.000000000e+00 1.700000000e-04 1.000000000e+00 1.700010000e-04 0.000000000e+00 1.706750000e-04 0.000000000e+00
+ 1.706760000e-04 1.000000000e+00 1.720000000e-04 1.000000000e+00 1.720010000e-04 0.000000000e+00 1.726750000e-04 0.000000000e+00
+ 1.726760000e-04 1.000000000e+00 1.740000000e-04 1.000000000e+00 1.740010000e-04 0.000000000e+00 1.746750000e-04 0.000000000e+00
+ 1.746760000e-04 1.000000000e+00 1.760000000e-04 1.000000000e+00 1.760010000e-04 0.000000000e+00 1.766750000e-04 0.000000000e+00
+ 1.766760000e-04 1.000000000e+00 1.780000000e-04 1.000000000e+00 1.780010000e-04 0.000000000e+00 1.786750000e-04 0.000000000e+00
+ 1.786760000e-04 1.000000000e+00 1.800000000e-04 1.000000000e+00 1.800010000e-04 0.000000000e+00 1.806750000e-04 0.000000000e+00
+ 1.806760000e-04 1.000000000e+00 1.820000000e-04 1.000000000e+00 1.820010000e-04 0.000000000e+00 1.826750000e-04 0.000000000e+00
+ 1.826760000e-04 1.000000000e+00 2.080000000e-04 1.000000000e+00 2.080010000e-04 0.000000000e+00 2.086750000e-04 0.000000000e+00
+ 2.086760000e-04 1.000000000e+00 2.100000000e-04 1.000000000e+00 2.100010000e-04 0.000000000e+00 2.106750000e-04 0.000000000e+00
+ 2.106760000e-04 1.000000000e+00 2.120000000e-04 1.000000000e+00 2.120010000e-04 0.000000000e+00 2.126750000e-04 0.000000000e+00
+ 2.126760000e-04 1.000000000e+00 2.140000000e-04 1.000000000e+00 2.140010000e-04 0.000000000e+00 2.146750000e-04 0.000000000e+00
+ 2.146760000e-04 1.000000000e+00 2.160000000e-04 1.000000000e+00 2.160010000e-04 0.000000000e+00 2.166750000e-04 0.000000000e+00
+ 2.166760000e-04 1.000000000e+00 2.180000000e-04 1.000000000e+00 2.180010000e-04 0.000000000e+00 2.186750000e-04 0.000000000e+00
+ 2.186760000e-04 1.000000000e+00 2.200000000e-04 1.000000000e+00 2.200010000e-04 0.000000000e+00 2.206750000e-04 0.000000000e+00
+ 2.206760000e-04 1.000000000e+00 2.220000000e-04 1.000000000e+00 2.220010000e-04 0.000000000e+00 2.226750000e-04 0.000000000e+00
+ 2.226760000e-04 1.000000000e+00 2.240000000e-04 1.000000000e+00 2.240010000e-04 0.000000000e+00 2.246750000e-04 0.000000000e+00
+ 2.246760000e-04 1.000000000e+00 2.260000000e-04 1.000000000e+00 2.260010000e-04 0.000000000e+00 2.266750000e-04 0.000000000e+00
+ 2.266760000e-04 1.000000000e+00 2.280000000e-04 1.000000000e+00 2.280010000e-04 0.000000000e+00 2.286750000e-04 0.000000000e+00
+ 2.286760000e-04 1.000000000e+00 2.300000000e-04 1.000000000e+00 2.300010000e-04 0.000000000e+00 2.306750000e-04 0.000000000e+00
+ 2.306760000e-04 1.000000000e+00 2.320000000e-04 1.000000000e+00 2.320010000e-04 0.000000000e+00 2.326750000e-04 0.000000000e+00
+ 2.326760000e-04 1.000000000e+00 2.340000000e-04 1.000000000e+00 2.340010000e-04 0.000000000e+00 2.346750000e-04 0.000000000e+00
+ 2.346760000e-04 1.000000000e+00 2.360000000e-04 1.000000000e+00 2.360010000e-04 0.000000000e+00 2.366750000e-04 0.000000000e+00
+ 2.366760000e-04 1.000000000e+00 2.380000000e-04 1.000000000e+00 2.380010000e-04 0.000000000e+00 2.386750000e-04 0.000000000e+00
+ 2.386760000e-04 1.000000000e+00 2.400000000e-04 1.000000000e+00 2.400010000e-04 0.000000000e+00 2.406750000e-04 0.000000000e+00
+ 2.406760000e-04 1.000000000e+00 2.660000000e-04 1.000000000e+00 2.660010000e-04 0.000000000e+00 2.666750000e-04 0.000000000e+00
+ 2.666760000e-04 1.000000000e+00 2.680000000e-04 1.000000000e+00 2.680010000e-04 0.000000000e+00 2.686750000e-04 0.000000000e+00
+ 2.686760000e-04 1.000000000e+00 2.700000000e-04 1.000000000e+00 2.700010000e-04 0.000000000e+00 2.706750000e-04 0.000000000e+00
+ 2.706760000e-04 1.000000000e+00 2.720000000e-04 1.000000000e+00 2.720010000e-04 0.000000000e+00 2.726750000e-04 0.000000000e+00
+ 2.726760000e-04 1.000000000e+00 2.740000000e-04 1.000000000e+00 2.740010000e-04 0.000000000e+00 2.746750000e-04 0.000000000e+00
+ 2.746760000e-04 1.000000000e+00 2.760000000e-04 1.000000000e+00 2.760010000e-04 0.000000000e+00 2.766750000e-04 0.000000000e+00
+ 2.766760000e-04 1.000000000e+00 2.780000000e-04 1.000000000e+00 2.780010000e-04 0.000000000e+00 2.786750000e-04 0.000000000e+00
+ 2.786760000e-04 1.000000000e+00 2.800000000e-04 1.000000000e+00 2.800010000e-04 0.000000000e+00 2.806750000e-04 0.000000000e+00
+ 2.806760000e-04 1.000000000e+00 2.820000000e-04 1.000000000e+00 2.820010000e-04 0.000000000e+00 2.826750000e-04 0.000000000e+00
+ 2.826760000e-04 1.000000000e+00 2.840000000e-04 1.000000000e+00 2.840010000e-04 0.000000000e+00 2.846750000e-04 0.000000000e+00
+ 2.846760000e-04 1.000000000e+00 2.860000000e-04 1.000000000e+00 2.860010000e-04 0.000000000e+00 2.866750000e-04 0.000000000e+00
+ 2.866760000e-04 1.000000000e+00 2.880000000e-04 1.000000000e+00 2.880010000e-04 0.000000000e+00 2.886750000e-04 0.000000000e+00
+ 2.886760000e-04 1.000000000e+00 2.900000000e-04 1.000000000e+00 2.900010000e-04 0.000000000e+00 2.906750000e-04 0.000000000e+00
+ 2.906760000e-04 1.000000000e+00 2.920000000e-04 1.000000000e+00 2.920010000e-04 0.000000000e+00 2.926750000e-04 0.000000000e+00
+ 2.926760000e-04 1.000000000e+00 2.940000000e-04 1.000000000e+00 2.940010000e-04 0.000000000e+00 2.946750000e-04 0.000000000e+00
+ 2.946760000e-04 1.000000000e+00 2.960000000e-04 1.000000000e+00 2.960010000e-04 0.000000000e+00 2.966750000e-04 0.000000000e+00
+ 2.966760000e-04 1.000000000e+00 2.980000000e-04 1.000000000e+00 2.980010000e-04 0.000000000e+00 2.986750000e-04 0.000000000e+00
+ 2.986760000e-04 1.000000000e+00 3.240000000e-04 1.000000000e+00 3.240010000e-04 0.000000000e+00 3.246750000e-04 0.000000000e+00
+ 3.246760000e-04 1.000000000e+00 3.260000000e-04 1.000000000e+00 3.260010000e-04 0.000000000e+00 3.266750000e-04 0.000000000e+00
+ 3.266760000e-04 1.000000000e+00 3.280000000e-04 1.000000000e+00 3.280010000e-04 0.000000000e+00 3.286750000e-04 0.000000000e+00
+ 3.286760000e-04 1.000000000e+00 3.300000000e-04 1.000000000e+00 3.300010000e-04 0.000000000e+00 3.306750000e-04 0.000000000e+00
+ 3.306760000e-04 1.000000000e+00 3.320000000e-04 1.000000000e+00 3.320010000e-04 0.000000000e+00 3.326750000e-04 0.000000000e+00
+ 3.326760000e-04 1.000000000e+00 3.340000000e-04 1.000000000e+00 3.340010000e-04 0.000000000e+00 3.346750000e-04 0.000000000e+00
+ 3.346760000e-04 1.000000000e+00 3.360000000e-04 1.000000000e+00 3.360010000e-04 0.000000000e+00 3.366750000e-04 0.000000000e+00
+ 3.366760000e-04 1.000000000e+00 3.380000000e-04 1.000000000e+00 3.380010000e-04 0.000000000e+00 3.386750000e-04 0.000000000e+00
+ 3.386760000e-04 1.000000000e+00 3.400000000e-04 1.000000000e+00 3.400010000e-04 0.000000000e+00 3.406750000e-04 0.000000000e+00
+ 3.406760000e-04 1.000000000e+00 3.420000000e-04 1.000000000e+00 3.420010000e-04 0.000000000e+00 3.426750000e-04 0.000000000e+00
+ 3.426760000e-04 1.000000000e+00 3.440000000e-04 1.000000000e+00 3.440010000e-04 0.000000000e+00 3.446750000e-04 0.000000000e+00
+ 3.446760000e-04 1.000000000e+00 3.460000000e-04 1.000000000e+00 3.460010000e-04 0.000000000e+00 3.466750000e-04 0.000000000e+00
+ 3.466760000e-04 1.000000000e+00 3.480000000e-04 1.000000000e+00 3.480010000e-04 0.000000000e+00 3.486750000e-04 0.000000000e+00
+ 3.486760000e-04 1.000000000e+00 3.500000000e-04 1.000000000e+00 3.500010000e-04 0.000000000e+00 3.506750000e-04 0.000000000e+00
+ 3.506760000e-04 1.000000000e+00 3.520000000e-04 1.000000000e+00 3.520010000e-04 0.000000000e+00 3.526750000e-04 0.000000000e+00
+ 3.526760000e-04 1.000000000e+00 3.540000000e-04 1.000000000e+00 3.540010000e-04 0.000000000e+00 3.546750000e-04 0.000000000e+00
+ 3.546760000e-04 1.000000000e+00 3.560000000e-04 1.000000000e+00 3.560010000e-04 0.000000000e+00 3.566750000e-04 0.000000000e+00
+ 3.566760000e-04 1.000000000e+00)

.ic V(s0)=1.25 V(p0)=1.25 V(s1)=1.25 V(p1)=1.25 V(s2)=1.25 V(p2)=1.25 V(s3)=1.25 V(p3)=1.25 V(s4)=1.25 V(p4)=1.25 V(s5)=1.25 V(p5)=1.25 V(s6)=1.25 V(p6)=1.25 V(s7)=1.25 V(p7)=1.25 V(s8)=1.25 V(p8)=1.25 V(s9)=1.25 V(p9)=1.25 V(s10)=1.25 V(p10)=1.25 V(s11)=1.25 V(p11)=1.25 V(s12)=1.25 V(p12)=1.25 V(s13)=1.25 V(p13)=1.25 V(s14)=1.25 V(p14)=1.25 V(sh)=1.25
.tran 0 3.680000000e-04 0 5.000000000e-09
.save V(ain) V(mxo) V(bufo) V(sh) V(shc) V(vmid) V(s0) V(s1) V(s2) V(s3) V(s4) V(s5) V(s6) V(s7) V(s8) V(s9) V(s10) V(s11) V(s12) V(s13) V(s14) V(s15) V(f0) V(f1) V(f2) V(f3) V(f4) V(f5) V(f6) V(f7) V(f8) V(f9) V(f10) V(f11) V(f12) V(f13) V(f14) V(c0) V(c1) V(c2) V(c3) V(c4) V(c5) V(c6) V(c7) V(c8) V(c9) V(c10) V(c11) V(c12) V(c13) V(c14) V(c15)
.end
